.title Original two-terminal network

Vs supply 0 12.0

R1 supply a 1000.0

R2 a 0 2000.0

Vshort a 0 0

.options TEMP = 27C

.options TNOM = 27C

.options reltol = 1e-07

.options abstol = 1e-12

.options vntol = 1e-09

.op
.end
