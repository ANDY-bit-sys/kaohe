.title RC low-pass R=10k C=100n

Vin vin 0 DC 0 AC 1 PULSE(0 1 1m 1u 1u 10m 20m)

R1 vin vout 10000.0

C1 vout 0 1e-07

.options TEMP = 27C

.options TNOM = 27C

.options reltol = 1e-07

.options abstol = 1e-12

.options vntol = 1e-09

.tran 10u 50m 0 10u
.end
